* vdivider
* Schematic generated by Substrate
simulator lang=spectre
parameters vmax=1.8

simulator lang=spice
.subckt vdivider out vdd vss
XR1 vdd out resistor_2K
XR2 out vss resistor_1K
.ends vdivider
.subckt resistor_2K p n
R1 p n 2K
.ends resistor_2K
.subckt resistor_1K p n
R1 p n 1K
.ends resistor_1K

.subckt vdivider_tb vss
Vdd vdd vss dc vmax ac 1
Xdut out vdd vss vdivider
.ends

simulator lang=spectre
statistics {
  process {
  }
  mismatch {
    vary vmax dist=gauss std=1.8/0.25
  }
}
Xdut 0 vdivider_tb
